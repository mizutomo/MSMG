`include "disciplines.vams"

module DAC6 (Din,Aout, Vdd,Vss);
input [5:0] Din;          // digital input bus
output Aout;              // analog output
input Vdd,Vss;            // reference supply for output
electrical Aout,Vdd,Vss;

parameter real tr=10n;    // (sec) risetime for output changes
parameter real rout=1k;   // (ohms) output resistance
real kout;                // output as fraction of supply
real vout;                // continous analog output voltage

always begin
 if (^Din === 1'bx) kout=0; // if any bits invalid in Din, output is zero
 else kout = Din/63.0;      // else compute scale factor for output
 @(Din);                    // repeat whenever Din changes
end

analog begin
 vout = V(Vdd,Vss)*transition(kout,0,tr,tr); // ramp to fraction of supply
 I(Aout,Vss) <+ (V(Aout,Vss)-vout)/rout;     // drive output voltage+resistance
end
endmodule
