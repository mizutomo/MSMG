module mux0(SEL,IN0,IN1,OUT);
input SEL;     logic SEL;
input IN0,IN1;
output OUT;
electrical IN0,IN1,OUT;

parameter real Tr=1n;				// rise/fall time to change between states
real ASEL;

  analog begin
    ASEL = transition(SEL,0,Tr);		// ramp between 0 and 1
    V(OUT) <+ ASEL*V(IN1) + (1-ASEL)*V(IN0);	// ramp one on, one off on change
  end

end module
